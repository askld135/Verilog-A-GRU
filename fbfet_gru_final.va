`include "disciplines.vams"
`include "constants.vams"

module fbfet_gru(vout, clk, Lich, wf, Vd, Vg, h0_0, h0_1, h0_2, h0_3, h0_4, h0_5, h0_6, h0_7, h1_0, h1_1, h1_2, h1_3, h1_4, h1_5, h1_6, h1_7);
    input clk, Lich, wf, Vd, Vg, h0_0, h0_1, h0_2, h0_3, h0_4, h0_5, h0_6, h0_7, h1_0, h1_1, h1_2, h1_3, h1_4, h1_5, h1_6, h1_7;
    output vout, h0_0, h0_1, h0_2, h0_3, h0_4, h0_5, h0_6, h0_7, h1_0, h1_1, h1_2, h1_3, h1_4, h1_5, h1_6, h1_7;
    electrical vin, clk, Lich, wf, Vd, Vg, vout;

    electrical h0_0;
    electrical h0_1;
    electrical h0_2;
    electrical h0_3;
    electrical h0_4;
    electrical h0_5;
    electrical h0_6;
    electrical h0_7;
    electrical h1_0;
    electrical h1_1;
    electrical h1_2;
    electrical h1_3;
    electrical h1_4;
    electrical h1_5;
    electrical h1_6;
    electrical h1_7;

    // Regressor intermediate signal declarations
    real reg_layer1_0;
    real reg_layer1_out_0;
    real reg_layer1_1;
    real reg_layer1_out_1;
    real reg_layer1_2;
    real reg_layer1_out_2;
    real reg_layer1_3;
    real reg_layer1_out_3;
    real reg_layer1_4;
    real reg_layer1_out_4;
    real reg_layer1_5;
    real reg_layer1_out_5;
    real reg_layer1_6;
    real reg_layer1_out_6;
    real reg_layer1_7;
    real reg_layer1_out_7;
    real reg_layer2_0;
    real reg_out_0;

    // Function definitions
    function real sigmoid;
        input x;
        begin
            sigmoid = 1.0 / (1.0 + exp(-x));
        end
    endfunction

    function real relu;
        input x;
        begin
            if (x > 0) begin
                relu = x;
            end else begin
                relu = 0;
            end
        end
    endfunction

    // Internal real variable declarations for GRU Layer 0
    real z0_0, z0_1, z0_2, z0_3, z0_4, z0_5, z0_6, z0_7;
    real r0_0, r0_1, r0_2, r0_3, r0_4, r0_5, r0_6, r0_7;
    real htilde0_0, htilde0_1, htilde0_2, htilde0_3, htilde0_4, htilde0_5, htilde0_6, htilde0_7;
    real h0_new_0, h0_new_1, h0_new_2, h0_new_3, h0_new_4, h0_new_5, h0_new_6, h0_new_7;

    // Internal real variable declarations for GRU Layer 1
    real z1_0, z1_1, z1_2, z1_3, z1_4, z1_5, z1_6, z1_7;
    real r1_0, r1_1, r1_2, r1_3, r1_4, r1_5, r1_6, r1_7;
    real htilde1_0, htilde1_1, htilde1_2, htilde1_3, htilde1_4, htilde1_5, htilde1_6, htilde1_7;
    real h1_new_0, h1_new_1, h1_new_2, h1_new_3, h1_new_4, h1_new_5, h1_new_6, h1_new_7;

    // Regressor output
    real y;

    parameter real W_ih_l0_0_0_0 = 0.12103522568941116;
    parameter real W_ih_l0_0_0_1 = -0.21169225871562958;
    parameter real W_ih_l0_0_0_2 = -0.4126555323600769;
    parameter real W_ih_l0_0_0_3 = 0.3904372751712799;
    parameter real W_ih_l0_0_1_0 = 0.04522358998656273;
    parameter real W_ih_l0_0_1_1 = 0.2523896098136902;
    parameter real W_ih_l0_0_1_2 = 0.35325583815574646;
    parameter real W_ih_l0_0_1_3 = 0.2597910761833191;
    parameter real W_ih_l0_0_2_0 = 0.24955661594867706;
    parameter real W_ih_l0_0_2_1 = -0.21005749702453613;
    parameter real W_ih_l0_0_2_2 = 0.005206416826695204;
    parameter real W_ih_l0_0_2_3 = 0.592513382434845;
    parameter real W_ih_l0_0_3_0 = 0.5621057152748108;
    parameter real W_ih_l0_0_3_1 = -0.11995933204889297;
    parameter real W_ih_l0_0_3_2 = -0.12912240624427795;
    parameter real W_ih_l0_0_3_3 = 0.13508477807044983;
    parameter real W_ih_l0_0_4_0 = 0.2874217629432678;
    parameter real W_ih_l0_0_4_1 = -0.3114687204360962;
    parameter real W_ih_l0_0_4_2 = 0.18365298211574554;
    parameter real W_ih_l0_0_4_3 = 0.4473196268081665;
    parameter real W_ih_l0_0_5_0 = -0.13662222027778625;
    parameter real W_ih_l0_0_5_1 = 0.33458033204078674;
    parameter real W_ih_l0_0_5_2 = -0.08092543482780457;
    parameter real W_ih_l0_0_5_3 = -0.505098283290863;
    parameter real W_ih_l0_0_6_0 = 1.787216305732727;
    parameter real W_ih_l0_0_6_1 = -0.342268168926239;
    parameter real W_ih_l0_0_6_2 = 0.450686514377594;
    parameter real W_ih_l0_0_6_3 = -0.21877281367778778;
    parameter real W_ih_l0_0_7_0 = 0.04541797563433647;
    parameter real W_ih_l0_0_7_1 = 0.353652685880661;
    parameter real W_ih_l0_0_7_2 = 0.2557821273803711;
    parameter real W_ih_l0_0_7_3 = -0.47519367933273315;
    parameter real W_ih_l0_1_0_0 = 0.9608249068260193;
    parameter real W_ih_l0_1_0_1 = -0.6197864413261414;
    parameter real W_ih_l0_1_0_2 = -1.1433303356170654;
    parameter real W_ih_l0_1_0_3 = 0.32416802644729614;
    parameter real W_ih_l0_1_1_0 = 0.11529278755187988;
    parameter real W_ih_l0_1_1_1 = -0.01525068748742342;
    parameter real W_ih_l0_1_1_2 = 1.1832373142242432;
    parameter real W_ih_l0_1_1_3 = 0.14962038397789001;
    parameter real W_ih_l0_1_2_0 = 0.4869849383831024;
    parameter real W_ih_l0_1_2_1 = 0.047550737857818604;
    parameter real W_ih_l0_1_2_2 = 1.0031540393829346;
    parameter real W_ih_l0_1_2_3 = 1.1611535549163818;
    parameter real W_ih_l0_1_3_0 = -0.9398269057273865;
    parameter real W_ih_l0_1_3_1 = 0.5869284272193909;
    parameter real W_ih_l0_1_3_2 = 0.8320938348770142;
    parameter real W_ih_l0_1_3_3 = 0.3488723635673523;
    parameter real W_ih_l0_1_4_0 = 0.10975712537765503;
    parameter real W_ih_l0_1_4_1 = -0.3212239444255829;
    parameter real W_ih_l0_1_4_2 = -1.197843313217163;
    parameter real W_ih_l0_1_4_3 = 0.7713509798049927;
    parameter real W_ih_l0_1_5_0 = 0.265738844871521;
    parameter real W_ih_l0_1_5_1 = -0.4397016167640686;
    parameter real W_ih_l0_1_5_2 = -0.7254073619842529;
    parameter real W_ih_l0_1_5_3 = -0.6623499393463135;
    parameter real W_ih_l0_1_6_0 = 0.6572389602661133;
    parameter real W_ih_l0_1_6_1 = -0.18090763688087463;
    parameter real W_ih_l0_1_6_2 = -1.4903144836425781;
    parameter real W_ih_l0_1_6_3 = 0.025780778378248215;
    parameter real W_ih_l0_1_7_0 = 0.38462698459625244;
    parameter real W_ih_l0_1_7_1 = -0.17288945615291595;
    parameter real W_ih_l0_1_7_2 = -0.6185834407806396;
    parameter real W_ih_l0_1_7_3 = -1.236473560333252;
    parameter real W_ih_l0_2_0_0 = 0.1036062017083168;
    parameter real W_ih_l0_2_0_1 = -0.029175661504268646;
    parameter real W_ih_l0_2_0_2 = 0.21967223286628723;
    parameter real W_ih_l0_2_0_3 = 0.41213253140449524;
    parameter real W_ih_l0_2_1_0 = -0.10210707783699036;
    parameter real W_ih_l0_2_1_1 = 0.12560482323169708;
    parameter real W_ih_l0_2_1_2 = 0.46200844645500183;
    parameter real W_ih_l0_2_1_3 = -0.35595276951789856;
    parameter real W_ih_l0_2_2_0 = -0.19803103804588318;
    parameter real W_ih_l0_2_2_1 = -0.22463089227676392;
    parameter real W_ih_l0_2_2_2 = 0.16482572257518768;
    parameter real W_ih_l0_2_2_3 = 0.21747197210788727;
    parameter real W_ih_l0_2_3_0 = -0.24648946523666382;
    parameter real W_ih_l0_2_3_1 = -0.311901330947876;
    parameter real W_ih_l0_2_3_2 = 0.22910559177398682;
    parameter real W_ih_l0_2_3_3 = 0.2588500678539276;
    parameter real W_ih_l0_2_4_0 = 0.21635083854198456;
    parameter real W_ih_l0_2_4_1 = 0.0026072224136441946;
    parameter real W_ih_l0_2_4_2 = -0.16971205174922943;
    parameter real W_ih_l0_2_4_3 = 0.24640311300754547;
    parameter real W_ih_l0_2_5_0 = 0.15769541263580322;
    parameter real W_ih_l0_2_5_1 = 0.1223917230963707;
    parameter real W_ih_l0_2_5_2 = 0.107099749147892;
    parameter real W_ih_l0_2_5_3 = -0.26447048783302307;
    parameter real W_ih_l0_2_6_0 = 0.1856137216091156;
    parameter real W_ih_l0_2_6_1 = 0.14995145797729492;
    parameter real W_ih_l0_2_6_2 = -0.2519020140171051;
    parameter real W_ih_l0_2_6_3 = -0.030150044709444046;
    parameter real W_ih_l0_2_7_0 = -0.12526576220989227;
    parameter real W_ih_l0_2_7_1 = 0.09483160078525543;
    parameter real W_ih_l0_2_7_2 = -0.19448086619377136;
    parameter real W_ih_l0_2_7_3 = 0.45283710956573486;
    parameter real W_hh_l0_0_0_0 = -0.3200681209564209;
    parameter real W_hh_l0_0_0_1 = 0.4272558093070984;
    parameter real W_hh_l0_0_0_2 = -0.06158940866589546;
    parameter real W_hh_l0_0_0_3 = 0.21273201704025269;
    parameter real W_hh_l0_0_0_4 = 0.15096557140350342;
    parameter real W_hh_l0_0_0_5 = 0.13052791357040405;
    parameter real W_hh_l0_0_0_6 = -0.011185281910002232;
    parameter real W_hh_l0_0_0_7 = -0.23241843283176422;
    parameter real W_hh_l0_0_1_0 = -0.0390036404132843;
    parameter real W_hh_l0_0_1_1 = 0.6163027286529541;
    parameter real W_hh_l0_0_1_2 = -0.27429065108299255;
    parameter real W_hh_l0_0_1_3 = 0.4525337517261505;
    parameter real W_hh_l0_0_1_4 = -0.46773967146873474;
    parameter real W_hh_l0_0_1_5 = 0.32271912693977356;
    parameter real W_hh_l0_0_1_6 = 0.03532736748456955;
    parameter real W_hh_l0_0_1_7 = -0.45351430773735046;
    parameter real W_hh_l0_0_2_0 = 0.3829827904701233;
    parameter real W_hh_l0_0_2_1 = -0.11823024600744247;
    parameter real W_hh_l0_0_2_2 = -0.6246130466461182;
    parameter real W_hh_l0_0_2_3 = 0.05345916748046875;
    parameter real W_hh_l0_0_2_4 = 0.6381904482841492;
    parameter real W_hh_l0_0_2_5 = 0.22077228128910065;
    parameter real W_hh_l0_0_2_6 = -0.03627963736653328;
    parameter real W_hh_l0_0_2_7 = -0.2717043161392212;
    parameter real W_hh_l0_0_3_0 = -0.054372530430555344;
    parameter real W_hh_l0_0_3_1 = 0.5944177508354187;
    parameter real W_hh_l0_0_3_2 = 0.0752568319439888;
    parameter real W_hh_l0_0_3_3 = -0.09480475634336472;
    parameter real W_hh_l0_0_3_4 = -0.14027972519397736;
    parameter real W_hh_l0_0_3_5 = 0.10350187867879868;
    parameter real W_hh_l0_0_3_6 = 0.6255806684494019;
    parameter real W_hh_l0_0_3_7 = -0.1048426553606987;
    parameter real W_hh_l0_0_4_0 = 0.30083271861076355;
    parameter real W_hh_l0_0_4_1 = 0.11372551321983337;
    parameter real W_hh_l0_0_4_2 = -0.4579610228538513;
    parameter real W_hh_l0_0_4_3 = 0.14220842719078064;
    parameter real W_hh_l0_0_4_4 = 0.18047842383384705;
    parameter real W_hh_l0_0_4_5 = 0.14457151293754578;
    parameter real W_hh_l0_0_4_6 = 0.28798550367355347;
    parameter real W_hh_l0_0_4_7 = -0.23358294367790222;
    parameter real W_hh_l0_0_5_0 = 0.01124071516096592;
    parameter real W_hh_l0_0_5_1 = 0.3490598797798157;
    parameter real W_hh_l0_0_5_2 = 0.20957747101783752;
    parameter real W_hh_l0_0_5_3 = -0.04457114636898041;
    parameter real W_hh_l0_0_5_4 = -0.6406115889549255;
    parameter real W_hh_l0_0_5_5 = -0.39306962490081787;
    parameter real W_hh_l0_0_5_6 = -0.0449226088821888;
    parameter real W_hh_l0_0_5_7 = -0.2974434494972229;
    parameter real W_hh_l0_0_6_0 = 0.46872177720069885;
    parameter real W_hh_l0_0_6_1 = -0.6268219351768494;
    parameter real W_hh_l0_0_6_2 = -0.7307368516921997;
    parameter real W_hh_l0_0_6_3 = 0.07507114112377167;
    parameter real W_hh_l0_0_6_4 = 1.0731496810913086;
    parameter real W_hh_l0_0_6_5 = 1.0231467485427856;
    parameter real W_hh_l0_0_6_6 = 1.1730577945709229;
    parameter real W_hh_l0_0_6_7 = -0.9821454286575317;
    parameter real W_hh_l0_0_7_0 = 0.0550917349755764;
    parameter real W_hh_l0_0_7_1 = 0.11410508304834366;
    parameter real W_hh_l0_0_7_2 = 0.346413791179657;
    parameter real W_hh_l0_0_7_3 = 0.5274825096130371;
    parameter real W_hh_l0_0_7_4 = -0.41197407245635986;
    parameter real W_hh_l0_0_7_5 = -0.1843944936990738;
    parameter real W_hh_l0_0_7_6 = -0.37786099314689636;
    parameter real W_hh_l0_0_7_7 = -0.4654199182987213;
    parameter real W_hh_l0_1_0_0 = -0.8098850846290588;
    parameter real W_hh_l0_1_0_1 = -2.6940042972564697;
    parameter real W_hh_l0_1_0_2 = 0.07366231083869934;
    parameter real W_hh_l0_1_0_3 = -0.23828977346420288;
    parameter real W_hh_l0_1_0_4 = 0.04106149449944496;
    parameter real W_hh_l0_1_0_5 = 0.5999153256416321;
    parameter real W_hh_l0_1_0_6 = 0.48401111364364624;
    parameter real W_hh_l0_1_0_7 = 0.4761514961719513;
    parameter real W_hh_l0_1_1_0 = 0.9148175120353699;
    parameter real W_hh_l0_1_1_1 = 0.5593814849853516;
    parameter real W_hh_l0_1_1_2 = -0.18731118738651276;
    parameter real W_hh_l0_1_1_3 = 0.13806961476802826;
    parameter real W_hh_l0_1_1_4 = 0.4626133441925049;
    parameter real W_hh_l0_1_1_5 = -0.1480521559715271;
    parameter real W_hh_l0_1_1_6 = -0.6213526725769043;
    parameter real W_hh_l0_1_1_7 = -0.45840731263160706;
    parameter real W_hh_l0_1_2_0 = 1.1345007419586182;
    parameter real W_hh_l0_1_2_1 = 0.4297870099544525;
    parameter real W_hh_l0_1_2_2 = 0.4492538571357727;
    parameter real W_hh_l0_1_2_3 = 0.5870268940925598;
    parameter real W_hh_l0_1_2_4 = 0.5614675879478455;
    parameter real W_hh_l0_1_2_5 = -0.2278103530406952;
    parameter real W_hh_l0_1_2_6 = -0.15143509209156036;
    parameter real W_hh_l0_1_2_7 = 0.7668112516403198;
    parameter real W_hh_l0_1_3_0 = 0.02789834327995777;
    parameter real W_hh_l0_1_3_1 = -0.2838987708091736;
    parameter real W_hh_l0_1_3_2 = 2.120096445083618;
    parameter real W_hh_l0_1_3_3 = -0.11082831770181656;
    parameter real W_hh_l0_1_3_4 = -1.5678800344467163;
    parameter real W_hh_l0_1_3_5 = -0.8251094818115234;
    parameter real W_hh_l0_1_3_6 = -0.9301144480705261;
    parameter real W_hh_l0_1_3_7 = 1.659082293510437;
    parameter real W_hh_l0_1_4_0 = -1.1684921979904175;
    parameter real W_hh_l0_1_4_1 = -2.8503949642181396;
    parameter real W_hh_l0_1_4_2 = -0.08135280013084412;
    parameter real W_hh_l0_1_4_3 = -0.8435509204864502;
    parameter real W_hh_l0_1_4_4 = 0.15251889824867249;
    parameter real W_hh_l0_1_4_5 = -1.0550729036331177;
    parameter real W_hh_l0_1_4_6 = -0.529290497303009;
    parameter real W_hh_l0_1_4_7 = 1.6725643873214722;
    parameter real W_hh_l0_1_5_0 = -1.6142442226409912;
    parameter real W_hh_l0_1_5_1 = 0.08093561232089996;
    parameter real W_hh_l0_1_5_2 = -0.217184379696846;
    parameter real W_hh_l0_1_5_3 = -2.193578004837036;
    parameter real W_hh_l0_1_5_4 = -1.107264757156372;
    parameter real W_hh_l0_1_5_5 = 1.6827532052993774;
    parameter real W_hh_l0_1_5_6 = 3.164099931716919;
    parameter real W_hh_l0_1_5_7 = -1.7544362545013428;
    parameter real W_hh_l0_1_6_0 = -1.5929044485092163;
    parameter real W_hh_l0_1_6_1 = -3.9600706100463867;
    parameter real W_hh_l0_1_6_2 = -0.08906769752502441;
    parameter real W_hh_l0_1_6_3 = -1.4599817991256714;
    parameter real W_hh_l0_1_6_4 = 0.3268454074859619;
    parameter real W_hh_l0_1_6_5 = -1.5038925409317017;
    parameter real W_hh_l0_1_6_6 = -1.2999600172042847;
    parameter real W_hh_l0_1_6_7 = 2.6020095348358154;
    parameter real W_hh_l0_1_7_0 = -2.1300203800201416;
    parameter real W_hh_l0_1_7_1 = -1.3572529554367065;
    parameter real W_hh_l0_1_7_2 = 0.5642867088317871;
    parameter real W_hh_l0_1_7_3 = -0.5224774479866028;
    parameter real W_hh_l0_1_7_4 = -1.3436553478240967;
    parameter real W_hh_l0_1_7_5 = -0.1261751651763916;
    parameter real W_hh_l0_1_7_6 = 1.440810203552246;
    parameter real W_hh_l0_1_7_7 = -0.6464555263519287;
    parameter real W_hh_l0_2_0_0 = 0.10534034669399261;
    parameter real W_hh_l0_2_0_1 = 0.16957992315292358;
    parameter real W_hh_l0_2_0_2 = 0.09069924801588058;
    parameter real W_hh_l0_2_0_3 = 0.09325394034385681;
    parameter real W_hh_l0_2_0_4 = 0.037296026945114136;
    parameter real W_hh_l0_2_0_5 = 0.2373378425836563;
    parameter real W_hh_l0_2_0_6 = -0.36309903860092163;
    parameter real W_hh_l0_2_0_7 = -0.3833310604095459;
    parameter real W_hh_l0_2_1_0 = 0.3468824625015259;
    parameter real W_hh_l0_2_1_1 = 0.3397323489189148;
    parameter real W_hh_l0_2_1_2 = 0.18424014747142792;
    parameter real W_hh_l0_2_1_3 = 0.32433608174324036;
    parameter real W_hh_l0_2_1_4 = 0.0029903564136475325;
    parameter real W_hh_l0_2_1_5 = 0.18184025585651398;
    parameter real W_hh_l0_2_1_6 = 0.05879740044474602;
    parameter real W_hh_l0_2_1_7 = -0.37038418650627136;
    parameter real W_hh_l0_2_2_0 = 0.009673834778368473;
    parameter real W_hh_l0_2_2_1 = -0.41286349296569824;
    parameter real W_hh_l0_2_2_2 = 0.16621407866477966;
    parameter real W_hh_l0_2_2_3 = -0.16831035912036896;
    parameter real W_hh_l0_2_2_4 = -0.4639599323272705;
    parameter real W_hh_l0_2_2_5 = 0.15015602111816406;
    parameter real W_hh_l0_2_2_6 = 0.15569205582141876;
    parameter real W_hh_l0_2_2_7 = 0.6944252252578735;
    parameter real W_hh_l0_2_3_0 = -0.25948843359947205;
    parameter real W_hh_l0_2_3_1 = 0.12375631928443909;
    parameter real W_hh_l0_2_3_2 = -0.2232377976179123;
    parameter real W_hh_l0_2_3_3 = 0.042101070284843445;
    parameter real W_hh_l0_2_3_4 = 0.07492511719465256;
    parameter real W_hh_l0_2_3_5 = 0.1873079240322113;
    parameter real W_hh_l0_2_3_6 = 0.3468404710292816;
    parameter real W_hh_l0_2_3_7 = -0.32185468077659607;
    parameter real W_hh_l0_2_4_0 = 0.3251296877861023;
    parameter real W_hh_l0_2_4_1 = 0.20573461055755615;
    parameter real W_hh_l0_2_4_2 = -0.31292039155960083;
    parameter real W_hh_l0_2_4_3 = 0.2599738538265228;
    parameter real W_hh_l0_2_4_4 = 0.32514452934265137;
    parameter real W_hh_l0_2_4_5 = -0.16612297296524048;
    parameter real W_hh_l0_2_4_6 = 0.10634792596101761;
    parameter real W_hh_l0_2_4_7 = 0.309577614068985;
    parameter real W_hh_l0_2_5_0 = 0.3698224425315857;
    parameter real W_hh_l0_2_5_1 = -0.13831232488155365;
    parameter real W_hh_l0_2_5_2 = -0.16568489372730255;
    parameter real W_hh_l0_2_5_3 = 0.2878723740577698;
    parameter real W_hh_l0_2_5_4 = 0.1740121990442276;
    parameter real W_hh_l0_2_5_5 = 0.07955016195774078;
    parameter real W_hh_l0_2_5_6 = 0.32349374890327454;
    parameter real W_hh_l0_2_5_7 = -0.26814067363739014;
    parameter real W_hh_l0_2_6_0 = -0.2751883268356323;
    parameter real W_hh_l0_2_6_1 = 0.4789060354232788;
    parameter real W_hh_l0_2_6_2 = 0.15991464257240295;
    parameter real W_hh_l0_2_6_3 = 0.04793749377131462;
    parameter real W_hh_l0_2_6_4 = -0.7028400897979736;
    parameter real W_hh_l0_2_6_5 = 0.23997309803962708;
    parameter real W_hh_l0_2_6_6 = 0.32394176721572876;
    parameter real W_hh_l0_2_6_7 = -0.45730113983154297;
    parameter real W_hh_l0_2_7_0 = -0.15206637978553772;
    parameter real W_hh_l0_2_7_1 = 0.056998830288648605;
    parameter real W_hh_l0_2_7_2 = 0.016208894550800323;
    parameter real W_hh_l0_2_7_3 = 0.3331737220287323;
    parameter real W_hh_l0_2_7_4 = 0.07901894301176071;
    parameter real W_hh_l0_2_7_5 = -0.37987321615219116;
    parameter real W_hh_l0_2_7_6 = -0.2698061764240265;
    parameter real W_hh_l0_2_7_7 = 0.6042012572288513;
    parameter real b_l0_0_0 = -0.11113770306110382;
    parameter real b_l0_0_1 = 0.04803650826215744;
    parameter real b_l0_0_2 = 0.25560617446899414;
    parameter real b_l0_0_3 = -0.015660880133509636;
    parameter real b_l0_0_4 = -0.10890103131532669;
    parameter real b_l0_0_5 = 0.1139136403799057;
    parameter real b_l0_0_6 = 0.24534431099891663;
    parameter real b_l0_0_7 = 0.14762109518051147;
    parameter real b_l0_1_0 = -0.37121883034706116;
    parameter real b_l0_1_1 = 0.4539663791656494;
    parameter real b_l0_1_2 = 1.4851927757263184;
    parameter real b_l0_1_3 = 0.32364320755004883;
    parameter real b_l0_1_4 = 0.28738075494766235;
    parameter real b_l0_1_5 = -0.8646942377090454;
    parameter real b_l0_1_6 = 0.4254104495048523;
    parameter real b_l0_1_7 = 0.7925194501876831;
    parameter real b_l0_2_0 = -0.2615618109703064;
    parameter real b_l0_2_1 = -0.11885641515254974;
    parameter real b_l0_2_2 = 0.02550041489303112;
    parameter real b_l0_2_3 = -0.03137683868408203;
    parameter real b_l0_2_4 = -0.1524023711681366;
    parameter real b_l0_2_5 = -0.05016857385635376;
    parameter real b_l0_2_6 = 0.16157497465610504;
    parameter real b_l0_2_7 = 0.025200890377163887;

    parameter real W_ih_l1_0_0_0 = 0.820762574672699;
    parameter real W_ih_l1_0_0_1 = 1.4911367893218994;
    parameter real W_ih_l1_0_0_2 = 0.005482316482812166;
    parameter real W_ih_l1_0_0_3 = 0.01979038119316101;
    parameter real W_ih_l1_0_0_4 = 0.2077731341123581;
    parameter real W_ih_l1_0_0_5 = 0.9848180413246155;
    parameter real W_ih_l1_0_0_6 = 0.27253320813179016;
    parameter real W_ih_l1_0_0_7 = -0.716368556022644;
    parameter real W_ih_l1_0_1_0 = -0.3426479995250702;
    parameter real W_ih_l1_0_1_1 = 0.06600703299045563;
    parameter real W_ih_l1_0_1_2 = -0.5140622854232788;
    parameter real W_ih_l1_0_1_3 = 0.08266010135412216;
    parameter real W_ih_l1_0_1_4 = 0.8882362842559814;
    parameter real W_ih_l1_0_1_5 = -0.12027686834335327;
    parameter real W_ih_l1_0_1_6 = -0.9324522614479065;
    parameter real W_ih_l1_0_1_7 = 0.3987258970737457;
    parameter real W_ih_l1_0_2_0 = 0.14019323885440826;
    parameter real W_ih_l1_0_2_1 = 0.195415198802948;
    parameter real W_ih_l1_0_2_2 = -0.03257853910326958;
    parameter real W_ih_l1_0_2_3 = -0.06999646872282028;
    parameter real W_ih_l1_0_2_4 = 0.39804747700691223;
    parameter real W_ih_l1_0_2_5 = -0.2800372838973999;
    parameter real W_ih_l1_0_2_6 = -0.5020630359649658;
    parameter real W_ih_l1_0_2_7 = -0.29420551657676697;
    parameter real W_ih_l1_0_3_0 = 0.3225976526737213;
    parameter real W_ih_l1_0_3_1 = -0.04322541132569313;
    parameter real W_ih_l1_0_3_2 = 0.5837345719337463;
    parameter real W_ih_l1_0_3_3 = 0.04218265786767006;
    parameter real W_ih_l1_0_3_4 = 0.03686526045203209;
    parameter real W_ih_l1_0_3_5 = 0.24647346138954163;
    parameter real W_ih_l1_0_3_6 = 0.06684139370918274;
    parameter real W_ih_l1_0_3_7 = 0.2336820662021637;
    parameter real W_ih_l1_0_4_0 = 0.00878909695893526;
    parameter real W_ih_l1_0_4_1 = -0.6827887892723083;
    parameter real W_ih_l1_0_4_2 = -0.034425314515829086;
    parameter real W_ih_l1_0_4_3 = -0.5466793775558472;
    parameter real W_ih_l1_0_4_4 = 0.21575185656547546;
    parameter real W_ih_l1_0_4_5 = -0.2875502407550812;
    parameter real W_ih_l1_0_4_6 = -0.17319634556770325;
    parameter real W_ih_l1_0_4_7 = -0.005148231517523527;
    parameter real W_ih_l1_0_5_0 = -1.0094010829925537;
    parameter real W_ih_l1_0_5_1 = -0.7625820636749268;
    parameter real W_ih_l1_0_5_2 = 0.9282621741294861;
    parameter real W_ih_l1_0_5_3 = -0.02869519777595997;
    parameter real W_ih_l1_0_5_4 = 0.06790724396705627;
    parameter real W_ih_l1_0_5_5 = -0.43998900055885315;
    parameter real W_ih_l1_0_5_6 = 0.5577402710914612;
    parameter real W_ih_l1_0_5_7 = -0.08839362859725952;
    parameter real W_ih_l1_0_6_0 = 0.5820719599723816;
    parameter real W_ih_l1_0_6_1 = -0.06506515294313431;
    parameter real W_ih_l1_0_6_2 = -0.3460788130760193;
    parameter real W_ih_l1_0_6_3 = 0.7952365875244141;
    parameter real W_ih_l1_0_6_4 = 0.7255761623382568;
    parameter real W_ih_l1_0_6_5 = -0.22093378007411957;
    parameter real W_ih_l1_0_6_6 = 0.6612933278083801;
    parameter real W_ih_l1_0_6_7 = -0.23344963788986206;
    parameter real W_ih_l1_0_7_0 = -0.15662075579166412;
    parameter real W_ih_l1_0_7_1 = -0.6042144298553467;
    parameter real W_ih_l1_0_7_2 = -0.25899893045425415;
    parameter real W_ih_l1_0_7_3 = -0.5462542772293091;
    parameter real W_ih_l1_0_7_4 = 0.41729310154914856;
    parameter real W_ih_l1_0_7_5 = 0.07876518368721008;
    parameter real W_ih_l1_0_7_6 = -0.682618260383606;
    parameter real W_ih_l1_0_7_7 = -0.09036984294652939;
    parameter real W_ih_l1_1_0_0 = 0.8521485328674316;
    parameter real W_ih_l1_1_0_1 = 1.3396073579788208;
    parameter real W_ih_l1_1_0_2 = 0.5870229005813599;
    parameter real W_ih_l1_1_0_3 = 0.29598742723464966;
    parameter real W_ih_l1_1_0_4 = 0.2821183502674103;
    parameter real W_ih_l1_1_0_5 = 0.7372068166732788;
    parameter real W_ih_l1_1_0_6 = 0.7139125466346741;
    parameter real W_ih_l1_1_0_7 = -0.8975589275360107;
    parameter real W_ih_l1_1_1_0 = 0.017976252362132072;
    parameter real W_ih_l1_1_1_1 = 1.1198042631149292;
    parameter real W_ih_l1_1_1_2 = 0.8227152824401855;
    parameter real W_ih_l1_1_1_3 = -0.029503233730793;
    parameter real W_ih_l1_1_1_4 = -0.421636700630188;
    parameter real W_ih_l1_1_1_5 = 0.0707656741142273;
    parameter real W_ih_l1_1_1_6 = -1.5166633129119873;
    parameter real W_ih_l1_1_1_7 = 0.30228522419929504;
    parameter real W_ih_l1_1_2_0 = -1.3833427429199219;
    parameter real W_ih_l1_1_2_1 = -1.1781041622161865;
    parameter real W_ih_l1_1_2_2 = -0.008962552063167095;
    parameter real W_ih_l1_1_2_3 = -0.3222454786300659;
    parameter real W_ih_l1_1_2_4 = -0.929400622844696;
    parameter real W_ih_l1_1_2_5 = 0.34285610914230347;
    parameter real W_ih_l1_1_2_6 = 0.9928901195526123;
    parameter real W_ih_l1_1_2_7 = -1.6103286743164062;
    parameter real W_ih_l1_1_3_0 = 0.6119192242622375;
    parameter real W_ih_l1_1_3_1 = 0.7104157209396362;
    parameter real W_ih_l1_1_3_2 = -0.6776418089866638;
    parameter real W_ih_l1_1_3_3 = -0.6983482837677002;
    parameter real W_ih_l1_1_3_4 = 0.5900141000747681;
    parameter real W_ih_l1_1_3_5 = 0.5784857273101807;
    parameter real W_ih_l1_1_3_6 = -0.23689763247966766;
    parameter real W_ih_l1_1_3_7 = -1.0047603845596313;
    parameter real W_ih_l1_1_4_0 = 0.37169981002807617;
    parameter real W_ih_l1_1_4_1 = -0.34339407086372375;
    parameter real W_ih_l1_1_4_2 = 0.10130085796117783;
    parameter real W_ih_l1_1_4_3 = 0.27456918358802795;
    parameter real W_ih_l1_1_4_4 = 0.008231019601225853;
    parameter real W_ih_l1_1_4_5 = 0.026647206395864487;
    parameter real W_ih_l1_1_4_6 = -0.6448007225990295;
    parameter real W_ih_l1_1_4_7 = 0.2613334357738495;
    parameter real W_ih_l1_1_5_0 = -0.49402493238449097;
    parameter real W_ih_l1_1_5_1 = 1.1992895603179932;
    parameter real W_ih_l1_1_5_2 = 1.0098223686218262;
    parameter real W_ih_l1_1_5_3 = -0.43680888414382935;
    parameter real W_ih_l1_1_5_4 = -1.223024845123291;
    parameter real W_ih_l1_1_5_5 = 0.30525946617126465;
    parameter real W_ih_l1_1_5_6 = 0.16782313585281372;
    parameter real W_ih_l1_1_5_7 = 1.0200039148330688;
    parameter real W_ih_l1_1_6_0 = -0.7862622141838074;
    parameter real W_ih_l1_1_6_1 = -1.213228702545166;
    parameter real W_ih_l1_1_6_2 = 0.2540680170059204;
    parameter real W_ih_l1_1_6_3 = -0.2125546783208847;
    parameter real W_ih_l1_1_6_4 = -0.687868058681488;
    parameter real W_ih_l1_1_6_5 = 0.14373350143432617;
    parameter real W_ih_l1_1_6_6 = 0.13934391736984253;
    parameter real W_ih_l1_1_6_7 = -0.7063091397285461;
    parameter real W_ih_l1_1_7_0 = -1.1859911680221558;
    parameter real W_ih_l1_1_7_1 = -0.24025914072990417;
    parameter real W_ih_l1_1_7_2 = 0.26498085260391235;
    parameter real W_ih_l1_1_7_3 = 0.6862496137619019;
    parameter real W_ih_l1_1_7_4 = -2.480724573135376;
    parameter real W_ih_l1_1_7_5 = 0.18910646438598633;
    parameter real W_ih_l1_1_7_6 = 1.0841816663742065;
    parameter real W_ih_l1_1_7_7 = -0.8749517202377319;
    parameter real W_ih_l1_2_0_0 = 0.004533885978162289;
    parameter real W_ih_l1_2_0_1 = 0.6983488202095032;
    parameter real W_ih_l1_2_0_2 = -0.435102641582489;
    parameter real W_ih_l1_2_0_3 = 0.26485365629196167;
    parameter real W_ih_l1_2_0_4 = -0.343682199716568;
    parameter real W_ih_l1_2_0_5 = -0.10979443043470383;
    parameter real W_ih_l1_2_0_6 = -0.016977613791823387;
    parameter real W_ih_l1_2_0_7 = -0.03216977417469025;
    parameter real W_ih_l1_2_1_0 = 0.15395736694335938;
    parameter real W_ih_l1_2_1_1 = -0.47289374470710754;
    parameter real W_ih_l1_2_1_2 = -0.029386691749095917;
    parameter real W_ih_l1_2_1_3 = -0.03799808397889137;
    parameter real W_ih_l1_2_1_4 = 0.11111455410718918;
    parameter real W_ih_l1_2_1_5 = -0.2145034521818161;
    parameter real W_ih_l1_2_1_6 = 0.008287857286632061;
    parameter real W_ih_l1_2_1_7 = 0.26675286889076233;
    parameter real W_ih_l1_2_2_0 = 0.359529972076416;
    parameter real W_ih_l1_2_2_1 = -0.15275610983371735;
    parameter real W_ih_l1_2_2_2 = -0.20651279389858246;
    parameter real W_ih_l1_2_2_3 = 0.04750567302107811;
    parameter real W_ih_l1_2_2_4 = 0.3527105450630188;
    parameter real W_ih_l1_2_2_5 = -0.38420364260673523;
    parameter real W_ih_l1_2_2_6 = -0.12941794097423553;
    parameter real W_ih_l1_2_2_7 = 0.5413340926170349;
    parameter real W_ih_l1_2_3_0 = -0.4080621004104614;
    parameter real W_ih_l1_2_3_1 = -0.3471790850162506;
    parameter real W_ih_l1_2_3_2 = 0.08724694699048996;
    parameter real W_ih_l1_2_3_3 = -0.19733239710330963;
    parameter real W_ih_l1_2_3_4 = -0.06351776421070099;
    parameter real W_ih_l1_2_3_5 = 0.3287399113178253;
    parameter real W_ih_l1_2_3_6 = -0.09311356395483017;
    parameter real W_ih_l1_2_3_7 = -0.17097431421279907;
    parameter real W_ih_l1_2_4_0 = -0.19009043276309967;
    parameter real W_ih_l1_2_4_1 = -0.18002888560295105;
    parameter real W_ih_l1_2_4_2 = 0.010001087561249733;
    parameter real W_ih_l1_2_4_3 = -0.27249497175216675;
    parameter real W_ih_l1_2_4_4 = 0.13287480175495148;
    parameter real W_ih_l1_2_4_5 = -0.04886779934167862;
    parameter real W_ih_l1_2_4_6 = -0.1691775619983673;
    parameter real W_ih_l1_2_4_7 = -0.4709914028644562;
    parameter real W_ih_l1_2_5_0 = -0.18745504319667816;
    parameter real W_ih_l1_2_5_1 = 0.3047936260700226;
    parameter real W_ih_l1_2_5_2 = 0.25265562534332275;
    parameter real W_ih_l1_2_5_3 = 0.16740605235099792;
    parameter real W_ih_l1_2_5_4 = 0.2624583840370178;
    parameter real W_ih_l1_2_5_5 = 0.4538087844848633;
    parameter real W_ih_l1_2_5_6 = -0.044769518077373505;
    parameter real W_ih_l1_2_5_7 = 0.3324359655380249;
    parameter real W_ih_l1_2_6_0 = 0.0277954563498497;
    parameter real W_ih_l1_2_6_1 = -0.3857104182243347;
    parameter real W_ih_l1_2_6_2 = -0.11209261417388916;
    parameter real W_ih_l1_2_6_3 = -0.34660252928733826;
    parameter real W_ih_l1_2_6_4 = 0.584199070930481;
    parameter real W_ih_l1_2_6_5 = -0.12458376586437225;
    parameter real W_ih_l1_2_6_6 = -0.2418714314699173;
    parameter real W_ih_l1_2_6_7 = 0.2684985399246216;
    parameter real W_ih_l1_2_7_0 = -0.5051217675209045;
    parameter real W_ih_l1_2_7_1 = -0.39501142501831055;
    parameter real W_ih_l1_2_7_2 = 0.08984833210706711;
    parameter real W_ih_l1_2_7_3 = -0.2113066464662552;
    parameter real W_ih_l1_2_7_4 = -0.38385337591171265;
    parameter real W_ih_l1_2_7_5 = 0.3327430188655853;
    parameter real W_ih_l1_2_7_6 = -0.13595646619796753;
    parameter real W_ih_l1_2_7_7 = -0.32377514243125916;
    parameter real W_hh_l1_0_0_0 = 1.1417099237442017;
    parameter real W_hh_l1_0_0_1 = -1.312372088432312;
    parameter real W_hh_l1_0_0_2 = 0.1022847592830658;
    parameter real W_hh_l1_0_0_3 = -0.8794278502464294;
    parameter real W_hh_l1_0_0_4 = 0.16578631103038788;
    parameter real W_hh_l1_0_0_5 = -0.5929025411605835;
    parameter real W_hh_l1_0_0_6 = -0.2502616047859192;
    parameter real W_hh_l1_0_0_7 = -0.4861045777797699;
    parameter real W_hh_l1_0_1_0 = 0.3285048305988312;
    parameter real W_hh_l1_0_1_1 = -1.0082926750183105;
    parameter real W_hh_l1_0_1_2 = 0.51349276304245;
    parameter real W_hh_l1_0_1_3 = -0.17316561937332153;
    parameter real W_hh_l1_0_1_4 = -0.4724139869213104;
    parameter real W_hh_l1_0_1_5 = 0.04655378684401512;
    parameter real W_hh_l1_0_1_6 = 0.5869969129562378;
    parameter real W_hh_l1_0_1_7 = -0.6334977149963379;
    parameter real W_hh_l1_0_2_0 = -0.08510777354240417;
    parameter real W_hh_l1_0_2_1 = -0.2729933559894562;
    parameter real W_hh_l1_0_2_2 = 0.3896952271461487;
    parameter real W_hh_l1_0_2_3 = 0.35753387212753296;
    parameter real W_hh_l1_0_2_4 = -0.0707862377166748;
    parameter real W_hh_l1_0_2_5 = -0.40767091512680054;
    parameter real W_hh_l1_0_2_6 = 0.13723857700824738;
    parameter real W_hh_l1_0_2_7 = -0.16884969174861908;
    parameter real W_hh_l1_0_3_0 = 0.19929739832878113;
    parameter real W_hh_l1_0_3_1 = 0.3680576682090759;
    parameter real W_hh_l1_0_3_2 = -0.08993726223707199;
    parameter real W_hh_l1_0_3_3 = 0.23058684170246124;
    parameter real W_hh_l1_0_3_4 = 0.04839705675840378;
    parameter real W_hh_l1_0_3_5 = 0.04695291072130203;
    parameter real W_hh_l1_0_3_6 = -0.041826874017715454;
    parameter real W_hh_l1_0_3_7 = 0.4441514015197754;
    parameter real W_hh_l1_0_4_0 = -0.8395720720291138;
    parameter real W_hh_l1_0_4_1 = 0.6608520150184631;
    parameter real W_hh_l1_0_4_2 = 0.03762497007846832;
    parameter real W_hh_l1_0_4_3 = 0.6499325037002563;
    parameter real W_hh_l1_0_4_4 = -0.07991988956928253;
    parameter real W_hh_l1_0_4_5 = -0.2468920350074768;
    parameter real W_hh_l1_0_4_6 = 0.3082265853881836;
    parameter real W_hh_l1_0_4_7 = -0.3054961860179901;
    parameter real W_hh_l1_0_5_0 = -0.2860260605812073;
    parameter real W_hh_l1_0_5_1 = 0.8870816230773926;
    parameter real W_hh_l1_0_5_2 = -0.37987926602363586;
    parameter real W_hh_l1_0_5_3 = 0.6636894941329956;
    parameter real W_hh_l1_0_5_4 = 0.24254053831100464;
    parameter real W_hh_l1_0_5_5 = 0.3487536907196045;
    parameter real W_hh_l1_0_5_6 = 0.12364979088306427;
    parameter real W_hh_l1_0_5_7 = 0.6623470187187195;
    parameter real W_hh_l1_0_6_0 = -0.2834368944168091;
    parameter real W_hh_l1_0_6_1 = -0.11883459240198135;
    parameter real W_hh_l1_0_6_2 = 0.26352137327194214;
    parameter real W_hh_l1_0_6_3 = 0.14091236889362335;
    parameter real W_hh_l1_0_6_4 = 0.5893844366073608;
    parameter real W_hh_l1_0_6_5 = -0.6797700524330139;
    parameter real W_hh_l1_0_6_6 = -0.2655019164085388;
    parameter real W_hh_l1_0_6_7 = -0.3335954248905182;
    parameter real W_hh_l1_0_7_0 = 0.08691911399364471;
    parameter real W_hh_l1_0_7_1 = -0.3400946855545044;
    parameter real W_hh_l1_0_7_2 = 0.11193938553333282;
    parameter real W_hh_l1_0_7_3 = 0.13449466228485107;
    parameter real W_hh_l1_0_7_4 = 0.003330998355522752;
    parameter real W_hh_l1_0_7_5 = 0.2659953832626343;
    parameter real W_hh_l1_0_7_6 = 0.03945488482713699;
    parameter real W_hh_l1_0_7_7 = -0.011019567027688026;
    parameter real W_hh_l1_1_0_0 = 0.5475279092788696;
    parameter real W_hh_l1_1_0_1 = -0.9637332558631897;
    parameter real W_hh_l1_1_0_2 = 0.29026633501052856;
    parameter real W_hh_l1_1_0_3 = 0.7104753851890564;
    parameter real W_hh_l1_1_0_4 = -1.669226884841919;
    parameter real W_hh_l1_1_0_5 = -0.10368097573518753;
    parameter real W_hh_l1_1_0_6 = -0.06282491981983185;
    parameter real W_hh_l1_1_0_7 = -1.5440728664398193;
    parameter real W_hh_l1_1_1_0 = 1.0342285633087158;
    parameter real W_hh_l1_1_1_1 = -0.8982901573181152;
    parameter real W_hh_l1_1_1_2 = -0.13467687368392944;
    parameter real W_hh_l1_1_1_3 = -1.4609183073043823;
    parameter real W_hh_l1_1_1_4 = 0.8360878825187683;
    parameter real W_hh_l1_1_1_5 = 0.7708110213279724;
    parameter real W_hh_l1_1_1_6 = -0.03403673693537712;
    parameter real W_hh_l1_1_1_7 = -0.22638791799545288;
    parameter real W_hh_l1_1_2_0 = -0.4164532721042633;
    parameter real W_hh_l1_1_2_1 = 0.4640490412712097;
    parameter real W_hh_l1_1_2_2 = -2.7754828929901123;
    parameter real W_hh_l1_1_2_3 = 0.6875993013381958;
    parameter real W_hh_l1_1_2_4 = 1.752448558807373;
    parameter real W_hh_l1_1_2_5 = -0.8949076533317566;
    parameter real W_hh_l1_1_2_6 = -0.8528538346290588;
    parameter real W_hh_l1_1_2_7 = 2.88698148727417;
    parameter real W_hh_l1_1_3_0 = -0.1190035343170166;
    parameter real W_hh_l1_1_3_1 = -1.0326251983642578;
    parameter real W_hh_l1_1_3_2 = 0.5985579490661621;
    parameter real W_hh_l1_1_3_3 = 0.6270822882652283;
    parameter real W_hh_l1_1_3_4 = 0.8261963725090027;
    parameter real W_hh_l1_1_3_5 = -0.23573070764541626;
    parameter real W_hh_l1_1_3_6 = -0.1660292148590088;
    parameter real W_hh_l1_1_3_7 = -0.4537109434604645;
    parameter real W_hh_l1_1_4_0 = 0.2709749937057495;
    parameter real W_hh_l1_1_4_1 = -0.24791619181632996;
    parameter real W_hh_l1_1_4_2 = -0.05084678530693054;
    parameter real W_hh_l1_1_4_3 = -0.0842909887433052;
    parameter real W_hh_l1_1_4_4 = -0.015287109650671482;
    parameter real W_hh_l1_1_4_5 = 0.19232670962810516;
    parameter real W_hh_l1_1_4_6 = 1.422460913658142;
    parameter real W_hh_l1_1_4_7 = -0.03186115249991417;
    parameter real W_hh_l1_1_5_0 = -0.3663770854473114;
    parameter real W_hh_l1_1_5_1 = -0.041828710585832596;
    parameter real W_hh_l1_1_5_2 = -1.7530136108398438;
    parameter real W_hh_l1_1_5_3 = 0.28124791383743286;
    parameter real W_hh_l1_1_5_4 = -0.2850198447704315;
    parameter real W_hh_l1_1_5_5 = -0.1758354902267456;
    parameter real W_hh_l1_1_5_6 = 0.2638210654258728;
    parameter real W_hh_l1_1_5_7 = 0.2746730446815491;
    parameter real W_hh_l1_1_6_0 = -3.727764368057251;
    parameter real W_hh_l1_1_6_1 = 1.9239104986190796;
    parameter real W_hh_l1_1_6_2 = -2.1309475898742676;
    parameter real W_hh_l1_1_6_3 = 2.630161762237549;
    parameter real W_hh_l1_1_6_4 = -0.4861513078212738;
    parameter real W_hh_l1_1_6_5 = 0.8264516592025757;
    parameter real W_hh_l1_1_6_6 = 0.8443847298622131;
    parameter real W_hh_l1_1_6_7 = 2.013014316558838;
    parameter real W_hh_l1_1_7_0 = -0.7958895564079285;
    parameter real W_hh_l1_1_7_1 = 0.5650985836982727;
    parameter real W_hh_l1_1_7_2 = -4.5987548828125;
    parameter real W_hh_l1_1_7_3 = 0.8871392011642456;
    parameter real W_hh_l1_1_7_4 = 3.2996132373809814;
    parameter real W_hh_l1_1_7_5 = -2.2295567989349365;
    parameter real W_hh_l1_1_7_6 = -2.3930578231811523;
    parameter real W_hh_l1_1_7_7 = 15.023070335388184;
    parameter real W_hh_l1_2_0_0 = 0.5608108639717102;
    parameter real W_hh_l1_2_0_1 = -0.6745213866233826;
    parameter real W_hh_l1_2_0_2 = 0.0958295464515686;
    parameter real W_hh_l1_2_0_3 = -0.4820777177810669;
    parameter real W_hh_l1_2_0_4 = 0.07789639383554459;
    parameter real W_hh_l1_2_0_5 = -0.0498519092798233;
    parameter real W_hh_l1_2_0_6 = -0.11158975213766098;
    parameter real W_hh_l1_2_0_7 = -0.07945021986961365;
    parameter real W_hh_l1_2_1_0 = -0.45068374276161194;
    parameter real W_hh_l1_2_1_1 = 0.36110827326774597;
    parameter real W_hh_l1_2_1_2 = -0.3208526372909546;
    parameter real W_hh_l1_2_1_3 = 0.09049186110496521;
    parameter real W_hh_l1_2_1_4 = 0.17606034874916077;
    parameter real W_hh_l1_2_1_5 = 0.04451141133904457;
    parameter real W_hh_l1_2_1_6 = -0.11181088536977768;
    parameter real W_hh_l1_2_1_7 = 0.32336774468421936;
    parameter real W_hh_l1_2_2_0 = -0.25975683331489563;
    parameter real W_hh_l1_2_2_1 = -0.3933624029159546;
    parameter real W_hh_l1_2_2_2 = 0.07053899019956589;
    parameter real W_hh_l1_2_2_3 = 0.19181720912456512;
    parameter real W_hh_l1_2_2_4 = -0.05053049325942993;
    parameter real W_hh_l1_2_2_5 = -0.09106939285993576;
    parameter real W_hh_l1_2_2_6 = 0.11603839695453644;
    parameter real W_hh_l1_2_2_7 = -0.10404708981513977;
    parameter real W_hh_l1_2_3_0 = -0.5181261301040649;
    parameter real W_hh_l1_2_3_1 = 0.24139197170734406;
    parameter real W_hh_l1_2_3_2 = 0.010720225051045418;
    parameter real W_hh_l1_2_3_3 = 0.3982650339603424;
    parameter real W_hh_l1_2_3_4 = -0.040605247020721436;
    parameter real W_hh_l1_2_3_5 = 0.22808434069156647;
    parameter real W_hh_l1_2_3_6 = 0.05069030448794365;
    parameter real W_hh_l1_2_3_7 = -0.3539832830429077;
    parameter real W_hh_l1_2_4_0 = 0.47135129570961;
    parameter real W_hh_l1_2_4_1 = -0.36819988489151;
    parameter real W_hh_l1_2_4_2 = -0.4390726387500763;
    parameter real W_hh_l1_2_4_3 = -0.1693369448184967;
    parameter real W_hh_l1_2_4_4 = 0.1314697116613388;
    parameter real W_hh_l1_2_4_5 = -0.010779167525470257;
    parameter real W_hh_l1_2_4_6 = -0.3693373501300812;
    parameter real W_hh_l1_2_4_7 = 0.18533848226070404;
    parameter real W_hh_l1_2_5_0 = -0.7397498488426208;
    parameter real W_hh_l1_2_5_1 = 0.4616668224334717;
    parameter real W_hh_l1_2_5_2 = 0.16847138106822968;
    parameter real W_hh_l1_2_5_3 = 0.21042104065418243;
    parameter real W_hh_l1_2_5_4 = -0.857369065284729;
    parameter real W_hh_l1_2_5_5 = 0.5284071564674377;
    parameter real W_hh_l1_2_5_6 = 0.16747672855854034;
    parameter real W_hh_l1_2_5_7 = -7.999740046216175e-05;
    parameter real W_hh_l1_2_6_0 = -0.3374961018562317;
    parameter real W_hh_l1_2_6_1 = 0.2700643837451935;
    parameter real W_hh_l1_2_6_2 = 0.7317217588424683;
    parameter real W_hh_l1_2_6_3 = -0.4391610026359558;
    parameter real W_hh_l1_2_6_4 = -0.24804800748825073;
    parameter real W_hh_l1_2_6_5 = 0.353621244430542;
    parameter real W_hh_l1_2_6_6 = 0.5164971351623535;
    parameter real W_hh_l1_2_6_7 = -0.4345298707485199;
    parameter real W_hh_l1_2_7_0 = 0.11133894324302673;
    parameter real W_hh_l1_2_7_1 = 0.13735294342041016;
    parameter real W_hh_l1_2_7_2 = -0.11706513911485672;
    parameter real W_hh_l1_2_7_3 = 0.005219889804720879;
    parameter real W_hh_l1_2_7_4 = 0.44923147559165955;
    parameter real W_hh_l1_2_7_5 = -0.16999712586402893;
    parameter real W_hh_l1_2_7_6 = -0.20185203850269318;
    parameter real W_hh_l1_2_7_7 = -0.29427066445350647;
    parameter real b_l1_0_0 = 0.2516922354698181;
    parameter real b_l1_0_1 = -0.9495329856872559;
    parameter real b_l1_0_2 = -0.5433067083358765;
    parameter real b_l1_0_3 = -0.014872537925839424;
    parameter real b_l1_0_4 = 0.16633933782577515;
    parameter real b_l1_0_5 = 0.3109292984008789;
    parameter real b_l1_0_6 = 0.7532474994659424;
    parameter real b_l1_0_7 = -0.12526428699493408;
    parameter real b_l1_1_0 = 2.159593105316162;
    parameter real b_l1_1_1 = -0.8696964979171753;
    parameter real b_l1_1_2 = -0.19355928897857666;
    parameter real b_l1_1_3 = 1.3246653079986572;
    parameter real b_l1_1_4 = -0.1247096136212349;
    parameter real b_l1_1_5 = 0.06250208616256714;
    parameter real b_l1_1_6 = 0.4938333034515381;
    parameter real b_l1_1_7 = -0.13359929621219635;
    parameter real b_l1_2_0 = -0.10862608253955841;
    parameter real b_l1_2_1 = 0.08550555258989334;
    parameter real b_l1_2_2 = -0.11234749853610992;
    parameter real b_l1_2_3 = 0.1464303582906723;
    parameter real b_l1_2_4 = 0.04823412001132965;
    parameter real b_l1_2_5 = -0.05615803599357605;
    parameter real b_l1_2_6 = 0.05281267315149307;
    parameter real b_l1_2_7 = 0.020902182906866074;

    // Regressor first linear layer parameters
    parameter real W_reg1_0_0 = -0.20075832307338715;
    parameter real W_reg1_0_1 = 0.18024811148643494;
    parameter real W_reg1_0_2 = 0.5649837851524353;
    parameter real W_reg1_0_3 = 0.35211262106895447;
    parameter real W_reg1_0_4 = -0.10849136114120483;
    parameter real W_reg1_0_5 = 0.46556153893470764;
    parameter real W_reg1_0_6 = 0.6619423627853394;
    parameter real W_reg1_0_7 = -0.5398560166358948;
    parameter real W_reg1_1_0 = 0.03711170703172684;
    parameter real W_reg1_1_1 = 0.6698024868965149;
    parameter real W_reg1_1_2 = 0.27849724888801575;
    parameter real W_reg1_1_3 = 0.22821536660194397;
    parameter real W_reg1_1_4 = -0.3553127348423004;
    parameter real W_reg1_1_5 = 0.27283596992492676;
    parameter real W_reg1_1_6 = 0.38125696778297424;
    parameter real W_reg1_1_7 = 0.1089254841208458;
    parameter real W_reg1_2_0 = 0.34309127926826477;
    parameter real W_reg1_2_1 = -0.41171255707740784;
    parameter real W_reg1_2_2 = -0.1909959614276886;
    parameter real W_reg1_2_3 = -0.443447470664978;
    parameter real W_reg1_2_4 = 0.14266236126422882;
    parameter real W_reg1_2_5 = 0.46651312708854675;
    parameter real W_reg1_2_6 = 0.30787667632102966;
    parameter real W_reg1_2_7 = 0.5189787745475769;
    parameter real W_reg1_3_0 = -0.27001097798347473;
    parameter real W_reg1_3_1 = 0.051988646388053894;
    parameter real W_reg1_3_2 = 0.5901232361793518;
    parameter real W_reg1_3_3 = -0.497498482465744;
    parameter real W_reg1_3_4 = -0.45898059010505676;
    parameter real W_reg1_3_5 = -0.276127427816391;
    parameter real W_reg1_3_6 = 0.6584302186965942;
    parameter real W_reg1_3_7 = 0.6047601103782654;
    parameter real W_reg1_4_0 = -0.31286343932151794;
    parameter real W_reg1_4_1 = -0.5672030448913574;
    parameter real W_reg1_4_2 = 0.017267445102334023;
    parameter real W_reg1_4_3 = -0.11727312207221985;
    parameter real W_reg1_4_4 = -0.17917348444461823;
    parameter real W_reg1_4_5 = -0.04395786672830582;
    parameter real W_reg1_4_6 = 0.0243246890604496;
    parameter real W_reg1_4_7 = 0.16626189649105072;
    parameter real W_reg1_5_0 = -0.3674485981464386;
    parameter real W_reg1_5_1 = 0.22482188045978546;
    parameter real W_reg1_5_2 = -0.0722789540886879;
    parameter real W_reg1_5_3 = 0.08735930919647217;
    parameter real W_reg1_5_4 = -0.2119598537683487;
    parameter real W_reg1_5_5 = 0.15917401015758514;
    parameter real W_reg1_5_6 = 0.518878698348999;
    parameter real W_reg1_5_7 = -0.48786893486976624;
    parameter real W_reg1_6_0 = -0.34784117341041565;
    parameter real W_reg1_6_1 = -0.09931089729070663;
    parameter real W_reg1_6_2 = -0.30740439891815186;
    parameter real W_reg1_6_3 = 0.4683294892311096;
    parameter real W_reg1_6_4 = -0.25490260124206543;
    parameter real W_reg1_6_5 = -0.3681613802909851;
    parameter real W_reg1_6_6 = -0.23849333822727203;
    parameter real W_reg1_6_7 = 0.4543174207210541;
    parameter real W_reg1_7_0 = 0.5079558491706848;
    parameter real W_reg1_7_1 = -0.4577026069164276;
    parameter real W_reg1_7_2 = 0.3337472677230835;
    parameter real W_reg1_7_3 = 0.16407547891139984;
    parameter real W_reg1_7_4 = -0.4368117153644562;
    parameter real W_reg1_7_5 = -0.2646813988685608;
    parameter real W_reg1_7_6 = -0.014474607072770596;
    parameter real W_reg1_7_7 = -0.43395888805389404;
    parameter real b_reg1_0 = 0.13348154723644257;
    parameter real b_reg1_1 = -0.10780496895313263;
    parameter real b_reg1_2 = -0.26672685146331787;
    parameter real b_reg1_3 = 0.14620043337345123;
    parameter real b_reg1_4 = 0.020160488784313202;
    parameter real b_reg1_5 = -0.10903545469045639;
    parameter real b_reg1_6 = 0.3081279397010803;
    parameter real b_reg1_7 = -0.009419135749340057;

    // Regressor second linear layer parameters
    parameter real W_reg2_0_0 = 0.7850840091705322;
    parameter real W_reg2_0_1 = -0.7072385549545288;
    parameter real W_reg2_0_2 = -1.3682554960250854;
    parameter real W_reg2_0_3 = -0.18052054941654205;
    parameter real W_reg2_0_4 = -0.5840306282043457;
    parameter real W_reg2_0_5 = -0.456762433052063;
    parameter real W_reg2_0_6 = -0.18081355094909668;
    parameter real W_reg2_0_7 = 0.7476760149002075;
    parameter real b_reg2_0 = -0.06908860057592392;

    analog begin
            // --- GRU Layer 0 ---
            // 입력 벡터: {V(Lich), V(wf), V(Vd), V(Vg)}
            z0_0 = sigmoid((W_ih_l0_0_0_0 * V(Lich)) + (W_ih_l0_0_0_1 * V(wf)) + (W_ih_l0_0_0_2 * V(Vd)) + (W_ih_l0_0_0_3 * V(Vg)) + W_hh_l0_0_0_0 * V(h0_0) + b_l0_0_0);
            r0_0 = sigmoid((W_ih_l0_1_0_0 * V(Lich)) + (W_ih_l0_1_0_1 * V(wf)) + (W_ih_l0_1_0_2 * V(Vd)) + (W_ih_l0_1_0_3 * V(Vg)) + W_hh_l0_1_0_0 * V(h0_0) + b_l0_1_0);
            htilde0_0 = tanh((W_ih_l0_2_0_0 * V(Lich)) + (W_ih_l0_2_0_1 * V(wf)) + (W_ih_l0_2_0_2 * V(Vd)) + (W_ih_l0_2_0_3 * V(Vg)) + W_hh_l0_2_0_0 * (r0_0 * V(h0_0)) + b_l0_2_0);
            h0_new_0 = (1 - z0_0) * V(h0_0) + z0_0 * htilde0_0;
            V(h0_0) <+ h0_new_0;

            z0_1 = sigmoid((W_ih_l0_0_1_0 * V(Lich)) + (W_ih_l0_0_1_1 * V(wf)) + (W_ih_l0_0_1_2 * V(Vd)) + (W_ih_l0_0_1_3 * V(Vg)) + W_hh_l0_0_1_1 * V(h0_1) + b_l0_0_1);
            r0_1 = sigmoid((W_ih_l0_1_1_0 * V(Lich)) + (W_ih_l0_1_1_1 * V(wf)) + (W_ih_l0_1_1_2 * V(Vd)) + (W_ih_l0_1_1_3 * V(Vg)) + W_hh_l0_1_1_1 * V(h0_1) + b_l0_1_1);
            htilde0_1 = tanh((W_ih_l0_2_1_0 * V(Lich)) + (W_ih_l0_2_1_1 * V(wf)) + (W_ih_l0_2_1_2 * V(Vd)) + (W_ih_l0_2_1_3 * V(Vg)) + W_hh_l0_2_1_1 * (r0_1 * V(h0_1)) + b_l0_2_1);
            h0_new_1 = (1 - z0_1) * V(h0_1) + z0_1 * htilde0_1;
            V(h0_1) <+ h0_new_1;

            z0_2 = sigmoid((W_ih_l0_0_2_0 * V(Lich)) + (W_ih_l0_0_2_1 * V(wf)) + (W_ih_l0_0_2_2 * V(Vd)) + (W_ih_l0_0_2_3 * V(Vg)) + W_hh_l0_0_2_2 * V(h0_2) + b_l0_0_2);
            r0_2 = sigmoid((W_ih_l0_1_2_0 * V(Lich)) + (W_ih_l0_1_2_1 * V(wf)) + (W_ih_l0_1_2_2 * V(Vd)) + (W_ih_l0_1_2_3 * V(Vg)) + W_hh_l0_1_2_2 * V(h0_2) + b_l0_1_2);
            htilde0_2 = tanh((W_ih_l0_2_2_0 * V(Lich)) + (W_ih_l0_2_2_1 * V(wf)) + (W_ih_l0_2_2_2 * V(Vd)) + (W_ih_l0_2_2_3 * V(Vg)) + W_hh_l0_2_2_2 * (r0_2 * V(h0_2)) + b_l0_2_2);
            h0_new_2 = (1 - z0_2) * V(h0_2) + z0_2 * htilde0_2;
            V(h0_2) <+ h0_new_2;

            z0_3 = sigmoid((W_ih_l0_0_3_0 * V(Lich)) + (W_ih_l0_0_3_1 * V(wf)) + (W_ih_l0_0_3_2 * V(Vd)) + (W_ih_l0_0_3_3 * V(Vg)) + W_hh_l0_0_3_3 * V(h0_3) + b_l0_0_3);
            r0_3 = sigmoid((W_ih_l0_1_3_0 * V(Lich)) + (W_ih_l0_1_3_1 * V(wf)) + (W_ih_l0_1_3_2 * V(Vd)) + (W_ih_l0_1_3_3 * V(Vg)) + W_hh_l0_1_3_3 * V(h0_3) + b_l0_1_3);
            htilde0_3 = tanh((W_ih_l0_2_3_0 * V(Lich)) + (W_ih_l0_2_3_1 * V(wf)) + (W_ih_l0_2_3_2 * V(Vd)) + (W_ih_l0_2_3_3 * V(Vg)) + W_hh_l0_2_3_3 * (r0_3 * V(h0_3)) + b_l0_2_3);
            h0_new_3 = (1 - z0_3) * V(h0_3) + z0_3 * htilde0_3;
            V(h0_3) <+ h0_new_3;

            z0_4 = sigmoid((W_ih_l0_0_4_0 * V(Lich)) + (W_ih_l0_0_4_1 * V(wf)) + (W_ih_l0_0_4_2 * V(Vd)) + (W_ih_l0_0_4_3 * V(Vg)) + W_hh_l0_0_4_4 * V(h0_4) + b_l0_0_4);
            r0_4 = sigmoid((W_ih_l0_1_4_0 * V(Lich)) + (W_ih_l0_1_4_1 * V(wf)) + (W_ih_l0_1_4_2 * V(Vd)) + (W_ih_l0_1_4_3 * V(Vg)) + W_hh_l0_1_4_4 * V(h0_4) + b_l0_1_4);
            htilde0_4 = tanh((W_ih_l0_2_4_0 * V(Lich)) + (W_ih_l0_2_4_1 * V(wf)) + (W_ih_l0_2_4_2 * V(Vd)) + (W_ih_l0_2_4_3 * V(Vg)) + W_hh_l0_2_4_4 * (r0_4 * V(h0_4)) + b_l0_2_4);
            h0_new_4 = (1 - z0_4) * V(h0_4) + z0_4 * htilde0_4;
            V(h0_4) <+ h0_new_4;

            z0_5 = sigmoid((W_ih_l0_0_5_0 * V(Lich)) + (W_ih_l0_0_5_1 * V(wf)) + (W_ih_l0_0_5_2 * V(Vd)) + (W_ih_l0_0_5_3 * V(Vg)) + W_hh_l0_0_5_5 * V(h0_5) + b_l0_0_5);
            r0_5 = sigmoid((W_ih_l0_1_5_0 * V(Lich)) + (W_ih_l0_1_5_1 * V(wf)) + (W_ih_l0_1_5_2 * V(Vd)) + (W_ih_l0_1_5_3 * V(Vg)) + W_hh_l0_1_5_5 * V(h0_5) + b_l0_1_5);
            htilde0_5 = tanh((W_ih_l0_2_5_0 * V(Lich)) + (W_ih_l0_2_5_1 * V(wf)) + (W_ih_l0_2_5_2 * V(Vd)) + (W_ih_l0_2_5_3 * V(Vg)) + W_hh_l0_2_5_5 * (r0_5 * V(h0_5)) + b_l0_2_5);
            h0_new_5 = (1 - z0_5) * V(h0_5) + z0_5 * htilde0_5;
            V(h0_5) <+ h0_new_5;

            z0_6 = sigmoid((W_ih_l0_0_6_0 * V(Lich)) + (W_ih_l0_0_6_1 * V(wf)) + (W_ih_l0_0_6_2 * V(Vd)) + (W_ih_l0_0_6_3 * V(Vg)) + W_hh_l0_0_6_6 * V(h0_6) + b_l0_0_6);
            r0_6 = sigmoid((W_ih_l0_1_6_0 * V(Lich)) + (W_ih_l0_1_6_1 * V(wf)) + (W_ih_l0_1_6_2 * V(Vd)) + (W_ih_l0_1_6_3 * V(Vg)) + W_hh_l0_1_6_6 * V(h0_6) + b_l0_1_6);
            htilde0_6 = tanh((W_ih_l0_2_6_0 * V(Lich)) + (W_ih_l0_2_6_1 * V(wf)) + (W_ih_l0_2_6_2 * V(Vd)) + (W_ih_l0_2_6_3 * V(Vg)) + W_hh_l0_2_6_6 * (r0_6 * V(h0_6)) + b_l0_2_6);
            h0_new_6 = (1 - z0_6) * V(h0_6) + z0_6 * htilde0_6;
            V(h0_6) <+ h0_new_6;

            z0_7 = sigmoid((W_ih_l0_0_7_0 * V(Lich)) + (W_ih_l0_0_7_1 * V(wf)) + (W_ih_l0_0_7_2 * V(Vd)) + (W_ih_l0_0_7_3 * V(Vg)) + W_hh_l0_0_7_7 * V(h0_7) + b_l0_0_7);
            r0_7 = sigmoid((W_ih_l0_1_7_0 * V(Lich)) + (W_ih_l0_1_7_1 * V(wf)) + (W_ih_l0_1_7_2 * V(Vd)) + (W_ih_l0_1_7_3 * V(Vg)) + W_hh_l0_1_7_7 * V(h0_7) + b_l0_1_7);
            htilde0_7 = tanh((W_ih_l0_2_7_0 * V(Lich)) + (W_ih_l0_2_7_1 * V(wf)) + (W_ih_l0_2_7_2 * V(Vd)) + (W_ih_l0_2_7_3 * V(Vg)) + W_hh_l0_2_7_7 * (r0_7 * V(h0_7)) + b_l0_2_7);
            h0_new_7 = (1 - z0_7) * V(h0_7) + z0_7 * htilde0_7;
            V(h0_7) <+ h0_new_7;

            // --- GRU Layer 1 ---
            // 입력은 GRU Layer 0의 은닉 상태: V(h0_0), V(h0_1), ..., V(h0_7)
            z1_0 = sigmoid((W_ih_l1_0_0_0 * h0_new_0) + (W_ih_l1_0_0_1 * h0_new_1) + (W_ih_l1_0_0_2 * h0_new_2) + (W_ih_l1_0_0_3 * h0_new_3) + (W_ih_l1_0_0_4 * h0_new_4) + (W_ih_l1_0_0_5 * h0_new_5) + (W_ih_l1_0_0_6 * h0_new_6) + (W_ih_l1_0_0_7 * h0_new_7) + W_hh_l1_0_0_0 * V(h1_0) + b_l1_0_0);
            r1_0 = sigmoid((W_ih_l1_1_0_0 * h0_new_0) + (W_ih_l1_1_0_1 * h0_new_1) + (W_ih_l1_1_0_2 * h0_new_2) + (W_ih_l1_1_0_3 * h0_new_3) + (W_ih_l1_1_0_4 * h0_new_4) + (W_ih_l1_1_0_5 * h0_new_5) + (W_ih_l1_1_0_6 * h0_new_6) + (W_ih_l1_1_0_7 * h0_new_7) + W_hh_l1_1_0_0 * V(h1_0) + b_l1_1_0);
            htilde1_0 = tanh((W_ih_l1_2_0_0 * h0_new_0) + (W_ih_l1_2_0_1 * h0_new_1) + (W_ih_l1_2_0_2 * h0_new_2) + (W_ih_l1_2_0_3 * h0_new_3) + (W_ih_l1_2_0_4 * h0_new_4) + (W_ih_l1_2_0_5 * h0_new_5) + (W_ih_l1_2_0_6 * h0_new_6) + (W_ih_l1_2_0_7 * h0_new_7) + W_hh_l1_2_0_0 * (r1_0 * V(h1_0)) + b_l1_2_0);
            h1_new_0 = (1 - z1_0) * V(h1_0) + z1_0 * htilde1_0;
            V(h1_0) <+ h1_new_0;

            z1_1 = sigmoid((W_ih_l1_0_1_0 * h0_new_0) + (W_ih_l1_0_1_1 * h0_new_1) + (W_ih_l1_0_1_2 * h0_new_2) + (W_ih_l1_0_1_3 * h0_new_3) + (W_ih_l1_0_1_4 * h0_new_4) + (W_ih_l1_0_1_5 * h0_new_5) + (W_ih_l1_0_1_6 * h0_new_6) + (W_ih_l1_0_1_7 * h0_new_7) + W_hh_l1_0_1_1 * V(h1_1) + b_l1_0_1);
            r1_1 = sigmoid((W_ih_l1_1_1_0 * h0_new_0) + (W_ih_l1_1_1_1 * h0_new_1) + (W_ih_l1_1_1_2 * h0_new_2) + (W_ih_l1_1_1_3 * h0_new_3) + (W_ih_l1_1_1_4 * h0_new_4) + (W_ih_l1_1_1_5 * h0_new_5) + (W_ih_l1_1_1_6 * h0_new_6) + (W_ih_l1_1_1_7 * h0_new_7) + W_hh_l1_1_1_1 * V(h1_1) + b_l1_1_1);
            htilde1_1 = tanh((W_ih_l1_2_1_0 * h0_new_0) + (W_ih_l1_2_1_1 * h0_new_1) + (W_ih_l1_2_1_2 * h0_new_2) + (W_ih_l1_2_1_3 * h0_new_3) + (W_ih_l1_2_1_4 * h0_new_4) + (W_ih_l1_2_1_5 * h0_new_5) + (W_ih_l1_2_1_6 * h0_new_6) + (W_ih_l1_2_1_7 * h0_new_7) + W_hh_l1_2_1_1 * (r1_1 * V(h1_1)) + b_l1_2_1);
            h1_new_1 = (1 - z1_1) * V(h1_1) + z1_1 * htilde1_1;
            V(h1_1) <+ h1_new_1;

            z1_2 = sigmoid((W_ih_l1_0_2_0 * h0_new_0) + (W_ih_l1_0_2_1 * h0_new_1) + (W_ih_l1_0_2_2 * h0_new_2) + (W_ih_l1_0_2_3 * h0_new_3) + (W_ih_l1_0_2_4 * h0_new_4) + (W_ih_l1_0_2_5 * h0_new_5) + (W_ih_l1_0_2_6 * h0_new_6) + (W_ih_l1_0_2_7 * h0_new_7) + W_hh_l1_0_2_2 * V(h1_2) + b_l1_0_2);
            r1_2 = sigmoid((W_ih_l1_1_2_0 * h0_new_0) + (W_ih_l1_1_2_1 * h0_new_1) + (W_ih_l1_1_2_2 * h0_new_2) + (W_ih_l1_1_2_3 * h0_new_3) + (W_ih_l1_1_2_4 * h0_new_4) + (W_ih_l1_1_2_5 * h0_new_5) + (W_ih_l1_1_2_6 * h0_new_6) + (W_ih_l1_1_2_7 * h0_new_7) + W_hh_l1_1_2_2 * V(h1_2) + b_l1_1_2);
            htilde1_2 = tanh((W_ih_l1_2_2_0 * h0_new_0) + (W_ih_l1_2_2_1 * h0_new_1) + (W_ih_l1_2_2_2 * h0_new_2) + (W_ih_l1_2_2_3 * h0_new_3) + (W_ih_l1_2_2_4 * h0_new_4) + (W_ih_l1_2_2_5 * h0_new_5) + (W_ih_l1_2_2_6 * h0_new_6) + (W_ih_l1_2_2_7 * h0_new_7) + W_hh_l1_2_2_2 * (r1_2 * V(h1_2)) + b_l1_2_2);
            h1_new_2 = (1 - z1_2) * V(h1_2) + z1_2 * htilde1_2;
            V(h1_2) <+ h1_new_2;

            z1_3 = sigmoid((W_ih_l1_0_3_0 * h0_new_0) + (W_ih_l1_0_3_1 * h0_new_1) + (W_ih_l1_0_3_2 * h0_new_2) + (W_ih_l1_0_3_3 * h0_new_3) + (W_ih_l1_0_3_4 * h0_new_4) + (W_ih_l1_0_3_5 * h0_new_5) + (W_ih_l1_0_3_6 * h0_new_6) + (W_ih_l1_0_3_7 * h0_new_7) + W_hh_l1_0_3_3 * V(h1_3) + b_l1_0_3);
            r1_3 = sigmoid((W_ih_l1_1_3_0 * h0_new_0) + (W_ih_l1_1_3_1 * h0_new_1) + (W_ih_l1_1_3_2 * h0_new_2) + (W_ih_l1_1_3_3 * h0_new_3) + (W_ih_l1_1_3_4 * h0_new_4) + (W_ih_l1_1_3_5 * h0_new_5) + (W_ih_l1_1_3_6 * h0_new_6) + (W_ih_l1_1_3_7 * h0_new_7) + W_hh_l1_1_3_3 * V(h1_3) + b_l1_1_3);
            htilde1_3 = tanh((W_ih_l1_2_3_0 * h0_new_0) + (W_ih_l1_2_3_1 * h0_new_1) + (W_ih_l1_2_3_2 * h0_new_2) + (W_ih_l1_2_3_3 * h0_new_3) + (W_ih_l1_2_3_4 * h0_new_4) + (W_ih_l1_2_3_5 * h0_new_5) + (W_ih_l1_2_3_6 * h0_new_6) + (W_ih_l1_2_3_7 * h0_new_7) + W_hh_l1_2_3_3 * (r1_3 * V(h1_3)) + b_l1_2_3);
            h1_new_3 = (1 - z1_3) * V(h1_3) + z1_3 * htilde1_3;
            V(h1_3) <+ h1_new_3;

            z1_4 = sigmoid((W_ih_l1_0_4_0 * h0_new_0) + (W_ih_l1_0_4_1 * h0_new_1) + (W_ih_l1_0_4_2 * h0_new_2) + (W_ih_l1_0_4_3 * h0_new_3) + (W_ih_l1_0_4_4 * h0_new_4) + (W_ih_l1_0_4_5 * h0_new_5) + (W_ih_l1_0_4_6 * h0_new_6) + (W_ih_l1_0_4_7 * h0_new_7) + W_hh_l1_0_4_4 * V(h1_4) + b_l1_0_4);
            r1_4 = sigmoid((W_ih_l1_1_4_0 * h0_new_0) + (W_ih_l1_1_4_1 * h0_new_1) + (W_ih_l1_1_4_2 * h0_new_2) + (W_ih_l1_1_4_3 * h0_new_3) + (W_ih_l1_1_4_4 * h0_new_4) + (W_ih_l1_1_4_5 * h0_new_5) + (W_ih_l1_1_4_6 * h0_new_6) + (W_ih_l1_1_4_7 * h0_new_7) + W_hh_l1_1_4_4 * V(h1_4) + b_l1_1_4);
            htilde1_4 = tanh((W_ih_l1_2_4_0 * h0_new_0) + (W_ih_l1_2_4_1 * h0_new_1) + (W_ih_l1_2_4_2 * h0_new_2) + (W_ih_l1_2_4_3 * h0_new_3) + (W_ih_l1_2_4_4 * h0_new_4) + (W_ih_l1_2_4_5 * h0_new_5) + (W_ih_l1_2_4_6 * h0_new_6) + (W_ih_l1_2_4_7 * h0_new_7) + W_hh_l1_2_4_4 * (r1_4 * V(h1_4)) + b_l1_2_4);
            h1_new_4 = (1 - z1_4) * V(h1_4) + z1_4 * htilde1_4;
            V(h1_4) <+ h1_new_4;

            z1_5 = sigmoid((W_ih_l1_0_5_0 * h0_new_0) + (W_ih_l1_0_5_1 * h0_new_1) + (W_ih_l1_0_5_2 * h0_new_2) + (W_ih_l1_0_5_3 * h0_new_3) + (W_ih_l1_0_5_4 * h0_new_4) + (W_ih_l1_0_5_5 * h0_new_5) + (W_ih_l1_0_5_6 * h0_new_6) + (W_ih_l1_0_5_7 * h0_new_7) + W_hh_l1_0_5_5 * V(h1_5) + b_l1_0_5);
            r1_5 = sigmoid((W_ih_l1_1_5_0 * h0_new_0) + (W_ih_l1_1_5_1 * h0_new_1) + (W_ih_l1_1_5_2 * h0_new_2) + (W_ih_l1_1_5_3 * h0_new_3) + (W_ih_l1_1_5_4 * h0_new_4) + (W_ih_l1_1_5_5 * h0_new_5) + (W_ih_l1_1_5_6 * h0_new_6) + (W_ih_l1_1_5_7 * h0_new_7) + W_hh_l1_1_5_5 * V(h1_5) + b_l1_1_5);
            htilde1_5 = tanh((W_ih_l1_2_5_0 * h0_new_0) + (W_ih_l1_2_5_1 * h0_new_1) + (W_ih_l1_2_5_2 * h0_new_2) + (W_ih_l1_2_5_3 * h0_new_3) + (W_ih_l1_2_5_4 * h0_new_4) + (W_ih_l1_2_5_5 * h0_new_5) + (W_ih_l1_2_5_6 * h0_new_6) + (W_ih_l1_2_5_7 * h0_new_7) + W_hh_l1_2_5_5 * (r1_5 * V(h1_5)) + b_l1_2_5);
            h1_new_5 = (1 - z1_5) * V(h1_5) + z1_5 * htilde1_5;
            V(h1_5) <+ h1_new_5;

            z1_6 = sigmoid((W_ih_l1_0_6_0 * h0_new_0) + (W_ih_l1_0_6_1 * h0_new_1) + (W_ih_l1_0_6_2 * h0_new_2) + (W_ih_l1_0_6_3 * h0_new_3) + (W_ih_l1_0_6_4 * h0_new_4) + (W_ih_l1_0_6_5 * h0_new_5) + (W_ih_l1_0_6_6 * h0_new_6) + (W_ih_l1_0_6_7 * h0_new_7) + W_hh_l1_0_6_6 * V(h1_6) + b_l1_0_6);
            r1_6 = sigmoid((W_ih_l1_1_6_0 * h0_new_0) + (W_ih_l1_1_6_1 * h0_new_1) + (W_ih_l1_1_6_2 * h0_new_2) + (W_ih_l1_1_6_3 * h0_new_3) + (W_ih_l1_1_6_4 * h0_new_4) + (W_ih_l1_1_6_5 * h0_new_5) + (W_ih_l1_1_6_6 * h0_new_6) + (W_ih_l1_1_6_7 * h0_new_7) + W_hh_l1_1_6_6 * V(h1_6) + b_l1_1_6);
            htilde1_6 = tanh((W_ih_l1_2_6_0 * h0_new_0) + (W_ih_l1_2_6_1 * h0_new_1) + (W_ih_l1_2_6_2 * h0_new_2) + (W_ih_l1_2_6_3 * h0_new_3) + (W_ih_l1_2_6_4 * h0_new_4) + (W_ih_l1_2_6_5 * h0_new_5) + (W_ih_l1_2_6_6 * h0_new_6) + (W_ih_l1_2_6_7 * h0_new_7) + W_hh_l1_2_6_6 * (r1_6 * V(h1_6)) + b_l1_2_6);
            h1_new_6 = (1 - z1_6) * V(h1_6) + z1_6 * htilde1_6;
            V(h1_6) <+ h1_new_6;

            z1_7 = sigmoid((W_ih_l1_0_7_0 * h0_new_0) + (W_ih_l1_0_7_1 * h0_new_1) + (W_ih_l1_0_7_2 * h0_new_2) + (W_ih_l1_0_7_3 * h0_new_3) + (W_ih_l1_0_7_4 * h0_new_4) + (W_ih_l1_0_7_5 * h0_new_5) + (W_ih_l1_0_7_6 * h0_new_6) + (W_ih_l1_0_7_7 * h0_new_7) + W_hh_l1_0_7_7 * V(h1_7) + b_l1_0_7);
            r1_7 = sigmoid((W_ih_l1_1_7_0 * h0_new_0) + (W_ih_l1_1_7_1 * h0_new_1) + (W_ih_l1_1_7_2 * h0_new_2) + (W_ih_l1_1_7_3 * h0_new_3) + (W_ih_l1_1_7_4 * h0_new_4) + (W_ih_l1_1_7_5 * h0_new_5) + (W_ih_l1_1_7_6 * h0_new_6) + (W_ih_l1_1_7_7 * h0_new_7) + W_hh_l1_1_7_7 * V(h1_7) + b_l1_1_7);
            htilde1_7 = tanh((W_ih_l1_2_7_0 * h0_new_0) + (W_ih_l1_2_7_1 * h0_new_1) + (W_ih_l1_2_7_2 * h0_new_2) + (W_ih_l1_2_7_3 * h0_new_3) + (W_ih_l1_2_7_4 * h0_new_4) + (W_ih_l1_2_7_5 * h0_new_5) + (W_ih_l1_2_7_6 * h0_new_6) + (W_ih_l1_2_7_7 * h0_new_7) + W_hh_l1_2_7_7 * (r1_7 * V(h1_7)) + b_l1_2_7);
            h1_new_7 = (1 - z1_7) * V(h1_7) + z1_7 * htilde1_7;
            V(h1_7) <+ h1_new_7;

            // --- Regressor (Output Layer) ---
            // 첫 번째 regressor 선형층 + ReLU (입력: GRU Layer 1 은닉 상태)
            reg_layer1_0 = b_reg1_0 + W_reg1_0_0 * h1_new_0 + W_reg1_0_1 * h1_new_1 + W_reg1_0_2 * h1_new_2 + W_reg1_0_3 * h1_new_3 + W_reg1_0_4 * h1_new_4 + W_reg1_0_5 * h1_new_5 + W_reg1_0_6 * h1_new_6 + W_reg1_0_7 * h1_new_7;
            reg_layer1_out_0 = relu(reg_layer1_0);
            reg_layer1_1 = b_reg1_1 + W_reg1_1_0 * h1_new_0 + W_reg1_1_1 * h1_new_1 + W_reg1_1_2 * h1_new_2 + W_reg1_1_3 * h1_new_3 + W_reg1_1_4 * h1_new_4 + W_reg1_1_5 * h1_new_5 + W_reg1_1_6 * h1_new_6 + W_reg1_1_7 * h1_new_7;
            reg_layer1_out_1 = relu(reg_layer1_1);
            reg_layer1_2 = b_reg1_2 + W_reg1_2_0 * h1_new_0 + W_reg1_2_1 * h1_new_1 + W_reg1_2_2 * h1_new_2 + W_reg1_2_3 * h1_new_3 + W_reg1_2_4 * h1_new_4 + W_reg1_2_5 * h1_new_5 + W_reg1_2_6 * h1_new_6 + W_reg1_2_7 * h1_new_7;
            reg_layer1_out_2 = relu(reg_layer1_2);
            reg_layer1_3 = b_reg1_3 + W_reg1_3_0 * h1_new_0 + W_reg1_3_1 * h1_new_1 + W_reg1_3_2 * h1_new_2 + W_reg1_3_3 * h1_new_3 + W_reg1_3_4 * h1_new_4 + W_reg1_3_5 * h1_new_5 + W_reg1_3_6 * h1_new_6 + W_reg1_3_7 * h1_new_7;
            reg_layer1_out_3 = relu(reg_layer1_3);
            reg_layer1_4 = b_reg1_4 + W_reg1_4_0 * h1_new_0 + W_reg1_4_1 * h1_new_1 + W_reg1_4_2 * h1_new_2 + W_reg1_4_3 * h1_new_3 + W_reg1_4_4 * h1_new_4 + W_reg1_4_5 * h1_new_5 + W_reg1_4_6 * h1_new_6 + W_reg1_4_7 * h1_new_7;
            reg_layer1_out_4 = relu(reg_layer1_4);
            reg_layer1_5 = b_reg1_5 + W_reg1_5_0 * h1_new_0 + W_reg1_5_1 * h1_new_1 + W_reg1_5_2 * h1_new_2 + W_reg1_5_3 * h1_new_3 + W_reg1_5_4 * h1_new_4 + W_reg1_5_5 * h1_new_5 + W_reg1_5_6 * h1_new_6 + W_reg1_5_7 * h1_new_7;
            reg_layer1_out_5 = relu(reg_layer1_5);
            reg_layer1_6 = b_reg1_6 + W_reg1_6_0 * h1_new_0 + W_reg1_6_1 * h1_new_1 + W_reg1_6_2 * h1_new_2 + W_reg1_6_3 * h1_new_3 + W_reg1_6_4 * h1_new_4 + W_reg1_6_5 * h1_new_5 + W_reg1_6_6 * h1_new_6 + W_reg1_6_7 * h1_new_7;
            reg_layer1_out_6 = relu(reg_layer1_6);
            reg_layer1_7 = b_reg1_7 + W_reg1_7_0 * h1_new_0 + W_reg1_7_1 * h1_new_1 + W_reg1_7_2 * h1_new_2 + W_reg1_7_3 * h1_new_3 + W_reg1_7_4 * h1_new_4 + W_reg1_7_5 * h1_new_5 + W_reg1_7_6 * h1_new_6 + W_reg1_7_7 * h1_new_7;
            reg_layer1_out_7 = relu(reg_layer1_7);

            // 두 번째 regressor 선형층 + ReLU
            reg_layer2_0 = b_reg2_0 + W_reg2_0_0 * reg_layer1_out_0 + W_reg2_0_1 * reg_layer1_out_1 + W_reg2_0_2 * reg_layer1_out_2 + W_reg2_0_3 * reg_layer1_out_3 + W_reg2_0_4 * reg_layer1_out_4 + W_reg2_0_5 * reg_layer1_out_5 + W_reg2_0_6 * reg_layer1_out_6 + W_reg2_0_7 * reg_layer1_out_7;
            reg_out_0 = relu(reg_layer2_0);
            y = reg_out_0;
            V(vout) <+ y;
    end
endmodule
